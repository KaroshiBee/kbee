* SPDX-License-Identifier: CERN-OHL-W-2.0-or-later
* Copyright (c) 2026 Karoshibee LTD
.include ../include/behavioural.inc

.subckt kbee_classify Vd Vz
Xcl Vd Vz classify_digit
.ends kbee_classify

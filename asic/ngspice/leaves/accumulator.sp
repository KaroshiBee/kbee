* SPDX-License-Identifier: CERN-OHL-W-2.0-or-later
* Copyright (c) 2026 Karoshibee LTD
.include ../include/behavioural.inc

.subckt kbee_accum_inject Vy Vy_prev Vinc Ven
Xai Vy Vy_prev Vinc Ven accum_inject
.ends kbee_accum_inject
